* CMOS LDO Regulator - PSRR (Power Supply Rejection Ratio) Characterization
* Simulates PSRR = 20*log10(v_dd / v_out) from 10 Hz to 100 MHz.

.param ILOAD = 10m

* AC Perturbation on VDD
VDD VDD 0 DC 5.0 AC 1.0
VREF VREF 0 DC 1.2
VNBIAS NBIAS 0 DC 1.2

* Feedback Resistor Divider
R1 VOUT VFEEDBACK 200k
R2 VFEEDBACK 0 114k

* Error Amplifier Stage 1: NMOS Differential Pair with PMOS Mirror Load
M4 N1 VREF TAIL 0 NMOS_GEN W=10u L=1u
M5 N2 VFEEDBACK TAIL 0 NMOS_GEN W=10u L=1u
I_TAIL TAIL 0 DC 50u
M2 N1 N1 VDD VDD PMOS_GEN W=10u L=1u
M3 N2 N1 VDD VDD PMOS_GEN W=10u L=1u

* Error Amplifier Stage 2
M6 VGATE N2 0 0 NMOS_GEN W=20u L=1u
M7 VGATE NBIAS VDD VDD PMOS_GEN W=20u L=1u
R3 N2 VMILLER 1k
C2 VMILLER VGATE 100f

* Pass Transistors
M1 VOUT VGATE VDD VDD PMOS_GEN W=200u L=1u
MP1 VOUT VGATE VDD VDD PMOS_GEN W=200u L=1u

* Output Filtering and Load
C1 VOUT 0 1u
I_LOAD VOUT 0 DC {ILOAD}

* Level-1 Models
.model NMOS_GEN NMOS (LEVEL=1 VTO=0.7 KP=120u GAMMA=0.45 PHI=0.65 LAMBDA=0.02 TOX=10n)
.model PMOS_GEN PMOS (LEVEL=1 VTO=-0.7 KP=50u GAMMA=0.4 PHI=0.65 LAMBDA=0.02 TOX=10n)

* AC Analysis from 10Hz to 100MHz
.ac dec 20 10 100Meg

* Measurement: PSRR at 100Hz, 1kHz, 10kHz, 100kHz, 1MHz
.meas AC PSRR_100Hz FIND mag(1/V(VOUT)) AT=100
.meas AC PSRR_1kHz FIND mag(1/V(VOUT)) AT=1k
.meas AC PSRR_10kHz FIND mag(1/V(VOUT)) AT=10k
.meas AC PSRR_100kHz FIND mag(1/V(VOUT)) AT=100k
.meas AC PSRR_1MHz FIND mag(1/V(VOUT)) AT=1Meg

.end
